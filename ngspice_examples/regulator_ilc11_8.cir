* VFD-filament regulator netlist for ILC1-1/8 (tube=ilc11_8)
* Generated from test_closed_loop.py make_netlist; matches the
* netlist that the corresponding regulator_ilc11_8.asc was
* converted from. Use to cross-check LTspice's generated netlist.

* Closed-loop VFD-filament regulator with thermal model

.include /home/lewisbrown/claude-code/smps-design-tools/ngspice_examples/uopamp.lib

.param T_amb=300.0
.param R_amb=2.46563
.param sigma_eps_A=4.483188e-13
.param C_th=9.181569e-05
.param fil_exp=1.2000

Vcc  vcc 0  9.0
Vee  vee 0 -9.0
* Buffer rails for the class-AB BJT collectors. Class-H envelope-tracking
* servo in booster mode (auto-tunes vcc_buf/vee_buf to V_top_pk + 0.3 V),
* fixed at VCC/VEE in non-booster mode (no buffers to power).
Vcc_buf vcc_buf 0 1.4
Vee_buf vee_buf 0 -1.4

* === Wien bridge oscillator (alpha=0.5) ===
R1   v_osc  ns   10000
C1   ns     np   1.591500e-08  IC=0
R2   np     0    10000
C2   np     0    1.591500e-08  IC=10m
Rg   nn     0    10k
Rfa  nn     fb   10k
Rfb  fb     v_osc  12k
Q1   fb     b1    v_osc Q2N3904
Q2   v_osc  b2    fb    Q2N3904
Rtop1 fb    b1    120000
Rbot1 b1    v_osc 120000
Rtop2 v_osc b2    120000
Rbot2 b2    fb    120000
XU_osc np nn vcc vee v_osc uopamp_lvl3 Avol=10meg GBW=4.5meg Rin=100g Rout=10 Iq=600u Ilimit=65m Vrail=100m Vmax=40 Vos=2.500000e-03

* === JFET-controlled all-pass: V_ap = V_osc * (1 - jwR_DS C)/(1 + jwR_DS C) ===
* All-pass input is taken from v_drv_atten: when a buffer chain is in use,
* this is v_drv_atten (low-Z attenuated signal from Buffer 0); otherwise it
* is v_osc directly. Attenuation keeps V_DS << V_GS-Vto so the JFET stays
* in its linear region, eliminating the asymmetric V_GS shift caused by the
* model's drain/source swap when V_DS reverses polarity.
R_ap1 v_drv_atten n_ap_minus 1590
R_ap2 v_ap  n_ap_minus 1590
* JFET variable resistor: single LS844 die. JFETs have no body diode, so
* the back-to-back MOSFET arrangement (needed to keep body diodes reverse-
* biased on both half-cycles) is unnecessary. The channel handles both
* V_DS polarities cleanly via its symmetric drain/source structure. R_DS
* in triode is 1/(2·β·(V_GS-V_p)); at LS844 typical (β=1.25 mS/V) and
* R_DS_target = 333 Ω, V_GS-V_p ≈ 1.2 V — moderate-overdrive triode,
* clean linear behaviour, low harmonic content (predicted 6-12 % H2 in
* this topology without bootstrap, down to 3 % with the bootstrap of
* commit e5017a4 adapted to the new summer topology).
*
* J_var uses the J_LS844 model (defined below). The matched die in the
* same LS844 package serves as Q_ref for the V_p-tracking V_offset
* reference, also using the same .model statement (so V_p and β are
* identical between J_var and Q_ref in simulation; in hardware the LS844
* on-die match guarantees ±5 mV V_GS, 5 % I_DSS).
*
* Drain = v_drv_atten (or v_osc on no-booster tubes), source = n_ap_plus.
* JFET is symmetric so either side could be drain — by convention we put
* the higher-voltage-swing side as drain.
J_var v_drv_atten v_ctl n_ap_plus J_LS844
.model J_LS844 NJF(Vto=-2.0000 Beta=1.2500e-03 Lambda=0.0000)
C_ap n_ap_plus 0 4.700000e-07    IC=0
XU_ap n_ap_plus n_ap_minus vcc vee v_ap uopamp_lvl3 Avol=10meg GBW=4.5meg Rin=100g Rout=10 Iq=600u Ilimit=65m Vrail=100m Vmax=40 Vos=2.500000e-03

* === Tube filament thermal-electrical macromodel ===
* The filament behaves as a non-linear resistor R(T) = R_amb*(T/T_amb)^fil_exp
* with thermal capacity C_th and radiative cooling sigma*eps*A*(T^4-T_amb^4).
* Encapsulated as a subcircuit so the controller netlist doesn't carry
* behavioural sources directly -- this is a model of the tube itself.
*   Terminals: v_top, v_bot   (filament endpoints, AC drive across these)
*              T_node          (internal thermal node, exposed for monitoring)
*              r_fil           (instantaneous R(T) as voltage, for monitoring)
* All physical parameters are global .params (R_amb, sigma_eps_A, C_th,
* T_amb, fil_exp) so a single instantiation is enough.
.subckt filament v_top v_bot T_node r_fil
* T_node is clamped via max(T, T_amb) in every formula. Physically the
* filament can't sit below ambient (no negative-temperature regime), so
* this clamp doesn't alter behaviour in the operating regime (T >= T_amb
* always). It exists purely as a numerical safety: without it, the
* adaptive solver can occasionally take a bad step where T_node dips
* below 0, at which point the T^4 cooling term explodes in sign and
* drives T_node to -inf in a few rejected timesteps. With the clamp,
* the worst case T_node briefly equals T_amb and the model just sits.
B_fil   v_top v_bot I = (V(v_top) - V(v_bot)) / (R_amb * (max(V(T_node),T_amb)/T_amb)^fil_exp)
B_pelec 0 T_node    I = (V(v_top)-V(v_bot))*(V(v_top)-V(v_bot)) / (R_amb * (max(V(T_node),T_amb)/T_amb)^fil_exp)
B_prad  T_node 0    I = sigma_eps_A * (max(V(T_node),T_amb)^4 - T_amb^4)
C_th    T_node 0    {C_th} IC=300.0
B_R     r_fil 0     V = R_amb * (max(V(T_node),T_amb)/T_amb)^fil_exp
.ends filament

* === AC Wheatstone bridge ===
* Filament arm: V_osc -> filament(thermal) -> node_A -> R_sense -> V_ap
X_filament v_osc_drive node_A T_node r_fil filament
R_sen node_A v_ap_drive 2
* Reference arm: V_osc -> R_top_ref -> node_B -> R_bot_ref -> V_ap.
* Bridge balance R_top_ref / R_bot_ref = R_op / R_sen targets R_op exactly.
R_top_ref v_osc_drive node_B 800
R_bot_ref node_B v_ap_drive  200

* === Difference amp (1-op-amp subtractor, gain 1) ===
* Loop polarity bookkeeping:
*   JFET-era: V_int_out + → V_ctl - (inverter) → V_GS_JFET - → pinched
*             → R_DS bigger → drive bigger. Cold filament needs more drive
*             → V_int_out +. Diff-amp natural wiring (n_diff = node_B -
*             node_A) gave cold → demod < 0 → inverting integrator winds
*             V_int_out +. Correct.
*   NMOS+level-shift (current): V_ctl = V_int_out + V_offset (non-inverting
*             summer). V_int_out + → V_ctl + → V_GS + → NMOS more on
*             → R_DS smaller → drive smaller. Cold filament needs more
*             drive → V_int_out -. Diff-amp SWAPPED (n_diff = node_A -
*             node_B) gives cold → demod > 0 → inverting integrator winds
*             V_int_out -. Correct.
* So the swap done for the PMOS era is also right for NMOS+level-shift,
* by coincidence of sign-flipping the (gate-drive polarity) twice
* (PMOS inversion AND inverter removal) — net result: opposite polarity
* from JFET, swapped diff-amp matches.
R_a1 node_A n_diff_plus  1e+06
R_a2 n_diff_plus  0      1e+06
R_b1 node_B n_diff_minus 1e+06
R_b2 n_diff_minus n_diff 1e+06
XU_diff n_diff_plus n_diff_minus vcc vee n_diff uopamp_lvl3 Avol=10meg GBW=4.5meg Rin=100g Rout=10 Iq=600u Ilimit=65m Vrail=100m Vmax=40 Vos=2.500000e-03

* === Comparator (behavioural sign of V_osc) ===
* Comparator: open-loop op-amp (one channel of the second TLV9154 quad).
* V+/V- swapped from the natural "sign of V_osc" connection ONLY when the
* CE booster is on (mc["ce_buf"]=True): in that topology Buffer 2 is an
* inverting summer (sign-flipped). The CC booster (default for non-mos_buf
* tubes like ILC1-1/7) uses non-inverting Buffers 1 and 2, no sign flip,
* so the comparator stays unswapped.
XU_cmp 0 v_osc vcc vee n_cmp uopamp_lvl3 Avol=10meg GBW=4.5meg Rin=100g Rout=10 Iq=600u Ilimit=65m Vrail=100m Vmax=40 Vos=2.500000e-03

* === Polarity-switching demodulator ===
.model swMod SW(VT=0 VH=0.1 RON=10 ROFF=1G)
S1 n_diff vplus n_cmp 0 swMod
S2 0      vplus 0     n_cmp swMod
R_bias vplus 0 1Meg
R_din n_diff n_dem_minus 10k
R_dfb n_demout n_dem_minus 10k
XU_dem vplus n_dem_minus vcc vee n_demout uopamp_lvl3 Avol=10meg GBW=4.5meg Rin=100g Rout=10 Iq=600u Ilimit=50m Vrail=100m Vmax=40 Vos=5.000000e-06

* === Integrator -> V_ctl (loop amp) ===
* V_ctl_raw = -1/(R*C) * integral(V_demout). Cold filament: V_demout < 0,
* so V_ctl_raw integrates positive. We want V_ctl negative when cold so
* the JFET stays pinched off. Wire B_invert to flip sign.
* PID compensator (single-op-amp form):
*   Input: R_INT || C_PID  (the parallel cap adds derivative action)
*   Feedback: R_PID in series with C_INT (the series R adds proportional)
* Transfer function: H(s) = -(R_PID + 1/sC_INT)(1 + sR_INT*C_PID) / R_INT
*   Ki = 1/(R_INT * C_INT)         integrator (DC dominates)
*   Kp = R_PID/R_INT + C_PID/C_INT proportional (mid-band)
*   Kd = R_PID * C_PID             derivative (HF, fights overshoot)
* === Log demod (compressive non-linearity between demod & integrator) ===
* LP filter on n_demout (cutoff 200 Hz) extracts DC component
* (rejects 2 kHz chop ripple so it doesn't alias into DC via the
* non-linearity). Then non-linear conformer (signed-log: gain=7.5, v_eps=5.00 mV):
*   log:  unit gain near 0, 1/(1+|V|/v_eps) compression at large signals
*   tanh: unit gain near 0, hard bound at ±V_sat at large signals
* Properties:
*   - same loop gain near OP (small-signal dynamics unchanged)
*   - bounded integrator wind rate during cold-start → bounded T_pk
R_lp_log    n_demout n_lp_dem  10k
C_lp_log    n_lp_dem 0        7.957747e-08
B_log_dem   n_log_dem 0  V = 0.0375 * (V(n_lp_dem) >= 0 ? ln(1+V(n_lp_dem)/0.005) : -ln(1+abs(V(n_lp_dem))/0.005))
R_intin  n_log_dem n_int_minus 70000
C_intin  n_log_dem n_int_minus 1.000000e-09
R_intfb  n_int_pidp v_int_raw 700000
* Realistic startup: cap begins uncharged (no IC). Loop self-starts from
* the intentional 1% bridge mismatch above + Vos drift in the demod and
* integrator op-amps.
C_intfb  n_int_minus n_int_pidp 3.183099e-07  IC=0
* HF rolloff cap: in parallel with R_PID to limit HF gain and suppress
* the f0 ripple from V_demod that the D term would otherwise pump
* through to V_ctl.
C_hf     n_int_pidp v_int_raw 1.000000e-09     IC=0
* Integrator op-amp output is v_int_raw (free-swinging, no clamp diodes
* on this node). The downstream-visible v_int_out is the upper-clamped
* version produced by the saturator (R_aw_out + D_aw_hi below). The
* back-calc path (R_bc + diff amp) feeds e_sat = v_int_raw - v_int_out
* into n_int_minus, unwinding the integrator only when v_int_raw is past
* the upper clamp -- zero effect when in range.
* DUAL-SUPPLY for the integrator. V_int_out_OP is slightly negative (~-0.4 V
* for ILC1-1/7) with the NMOS variable-R + level-shift architecture
* (V_ctl = V_int_out + V_offset). Cold-start: V_int_out winds from 0 toward
* OP through negative values; the NMOS pair is strongly on at cold start
* (V_GS ≈ V_offset = +2.5 V), so |1-H| ≈ 0 and the filament heats gently.
* No wrong-polarity basin (MOSFET gate is insulated; there's no equivalent
* of the JFET gate-source forward-conduction trap regardless of V_int_out
* sign).
XU_int 0 n_int_minus vcc vee v_int_raw uopamp_lvl3 Avol=10meg GBW=4.5meg Rin=100g Rout=10 Iq=600u Ilimit=50m Vrail=100m Vmax=40 Vos=5.000000e-06

* === Passive saturator + back-calculation anti-windup ===
* The integrator op-amp output v_int_raw drives v_int_out through a series
* resistor R_aw_out. A single upper clamp diode D_aw_hi clips v_int_out to
* V_clamp_hi + Vf. When v_int_raw exceeds the clamp, the clamp diode
* conducts, with current bounded by R_aw_out. The lower bound on v_int_out
* is the integrator op-amp's own VEE rail (no diode clamp needed; the
* NMOS+level-shift architecture has V_int_out_OP negative).
*
* R_aw_out = 10 ohm sizes for the loads on v_int_out (R_sum_a = 100k draws
* ~13 uA at OP; the diff amp's R_diff1 draws another ~5 uA): the load drop
* across R_aw_out is ~0.18 mV at OP, which through the back-calc resistor
* would give a ~1 nA bias current at the integrator input -- equivalent to
* ~0.3 K of steady-state T error. Cold-start clamp peak current is
* ~50 mA on ILC1-1/7 (only ~13 mA on IV-18) for ~40 ms during cold-start
* before the loop settles; this is at the OPA2188 chopper's typical Isc
* of 50 mA. OPA2188 datasheet rates 35 mA min / 65 mA typ; a min-spec
* part would current-limit at 35 mA during cold-start, slowing the
* integrator wind but the loop still converges. Verified by
* verify_opamp_currents.py + plot_convergence.py 2026-05-20. The diode
* itself sees the same current; BAS70 / 1N5819 Schottky rated 1 A
* continuous, plenty of margin.
* Clamp widened from +2.5 V to +6.0 V to give the loop room for the
* JMMBFJ112's V_p range (-1 to -5 V). With the +6 V upper clamp, V_ctl
* can swing to -6 V, comfortably accommodating worst-case V_p = -5 parts
* without engaging the clamp at OP. Cold-start kick still hits the clamp
* (which is the intended anti-windup behaviour during slew). The +/-9 V
* op-amp supplies easily accommodate +6 V on V_int_out.
V_clamp_hi v_clamp_hi 0  6
V_clamp_lo v_clamp_lo 0  -2.5
R_aw_out   v_int_raw  v_int_out  10
D_aw_hi    v_int_out  v_clamp_hi Dclamp
D_aw_lo    v_clamp_lo v_int_out  Dclamp
* Lower clamp at V_clamp_lo = -0.7 V → V_int_out floor ≈ -1.0 V (Schottky
* V_F ≈ 0.3 V at saturation current). Without it, the loop's proportional
* gain (Kp=10) sends V_int_out to the integrator's negative rail (~-5 V)
* in milliseconds at cold start, and the 100+ ms recovery from saturation
* drives a +68 K overshoot. With the clamp + back-calc anti-windup
* (R_bc), V_int_out is bounded at ~-1 V, anti-windup unwinds the
* integrator quickly when the loop transitions out of the cold-start
* high-error regime.
* Dclamp: switched 2026-05 from 1N4148-class to Schottky (BAT54 / 1N5819).
* Reason: at the worst-case clamp current (op-amp Isc ~50 mA chopper),
* the 1N4148's V_F was ~0.76 V; that meant the effective V_int_out floor
* sat at V_clamp_lo - 0.76 = -0.46 V even with V_clamp_lo = +0.3 V. V_ctl
* (via inverter, +1*V_int_out) crossed the JFET gate-source forward
* threshold (~0.6 V) on AC peaks, latching the loop in a "wrong-polarity"
* steady state where the JFET gate diode forward-conducts. With Schottky
* V_F ~0.3 V at 50 mA, the effective floor is V_clamp_lo - 0.3 ≈ 0 V,
* so V_ctl stays comfortably below the gate-conduction threshold. The
* lvl3 op-amp current verification (verify_opamp_currents.py) exposed
* the bistability when Ilimit was tightened from 1 A to 50/65 mA.
* Schottky (BAT54 / 1N5819 class). Higher SOA than 1N4148 for the
* worst-case clamp engagement current (~ Ilimit at full op-amp saturation).
.model Dclamp D(Is=10n N=1.0 RS=0.1 BV=40 IBV=0.1m CJO=10p)

* Difference op-amp: e_sat = v_int_raw - v_int_out (the "saturation error").
* Zero when v_int_out follows v_int_raw (no clamp current), positive when
* upper clamp diode conducts (v_int_raw > v_int_out), negative when lower
* clamp diode conducts. Standard 4-resistor difference topology, unity
* gain. Sign convention: v_int_raw is on the +IN side, v_int_out on the -IN
* side so e_sat = v_int_raw - v_int_out (so R_bc opposes integrator
* wind-up, not reinforces it).
R_diff1 v_int_out n_aw_diff_minus 100k
R_diff2 v_int_raw n_aw_diff_plus  100k
R_diff3 n_aw_diff_minus e_sat     100k
R_diff4 n_aw_diff_plus  0         100k
* Chopper-stabilized op-amp (Vos ~ 5 uV vs 2.5 mV for standard) for the
* back-calc diff amp. Tight Vos is essential here: e_sat's DC value is
* multiplied by 1/R_bc to become an integrator bias current, which the
* closed loop has to compensate with a corresponding steady-state demod
* error. With R_bc=R_INT (set below), the bias from a 2.5 mV Vos creates
* a ~33 K T error; chopper-class Vos cuts that to <0.1 K.
XU_aw_diff n_aw_diff_plus n_aw_diff_minus vcc vee e_sat uopamp_lvl3 Avol=10meg GBW=4.5meg Rin=100g Rout=10 Iq=600u Ilimit=50m Vrail=100m Vmax=40 Vos=5.000000e-06

* Back-calc resistor: routes e_sat to n_int_minus (integrator's summing
* junction). When v_int_raw > clamp_hi, e_sat > 0 -> injects positive current
* into n_int_minus, which the integrator counter-integrates -> v_int_raw is
* pulled back toward v_int_out at rate ~1/(R_bc * C_INT). Symmetric on the
* low side.
*
* Sizing: R_bc = R_INT sets the back-calc tracking time constant to
* R_INT*C_INT = ~9.5 ms, much faster than the thermal pole (100 ms) so
* anti-windup acts well within the regulator's response window. The DC
* leakage (chopper-class Vos -> e_sat offset -> bias current at
* n_int_minus) is negligible: 5 uV * 1 = 5 uV demand error, < 0.1 K.
R_bc e_sat n_int_minus 70000

* === Variable-R gate drive: unity-gain SUBTRACTOR with V_p-tracking shift ===
* V_ctl = V_int_out - V_source_ref, with V_source_ref produced by the
* self-biased J_ref above. At cold start V_int_out=0, V_ctl = -V_source_ref
* ≈ V_p/2 (negative), placing J_var at moderate-overdrive triode (R_DS
* a few hundred Ω, |1-H| moderate, bridge drive moderate). As V_int_out
* winds negative, V_ctl drops more negative, V_GS drops toward V_p,
* R_DS grows, drive grows.
*
* Why subtractor (not summer with -V_offset source): the self-biased
* Q_ref naturally produces a POSITIVE V_source_ref (current through R_src
* lifts the source above ground). Using V_source_ref directly via a
* subtractor (V_ctl = V_int_out - V_source_ref) gets the correct negative
* V_offset_effective without an extra inverter stage.
*
* The two LS844 dies are matched: V_GS_ref ≈ V_GS_var when both carry
* the same I, so V_GS_var_OP = V_int_out_OP - V_source_ref_OP is the same
* gate voltage referenced to V_p of both dies. Across the LS844 V_p spec
* (1.0-3.5 V), V_int_OP shifts to compensate; the loop converges on
* whatever value gives R_DS_OP ≈ 333 Ω for the bridge null.
*
* Standard 4-resistor diff-amp topology:
*   V_+IN  = V_int_out · R_gnd/(R_a + R_gnd)
*   V_-IN  = V(+IN)   (virtual short)
*   KCL at -IN: (V_source_ref - V_-IN)/R_b = (V_-IN - V_ctl)/R_fb
*   ⇒ V_ctl = V_+IN · (1 + R_fb/R_b) - V_source_ref · R_fb/R_b
*           = (R_fb/R_a) · V_int_out - (R_fb/R_b) · V_source_ref     (when R_a=R_gnd, R_b=R_fb)
*           = V_int_out - V_source_ref                                (all four R = 100k)
* V_p-tracking V_offset reference: LS844 die 2 wired self-biased.
* I_ref = (VCC - V_drain)/(R_d_ref); V_GS_ref = -I_ref·R_src_ref.
* V_source_ref (at n_ref_src) ≈ |V_p|/2 ≈ 1 V at typical LS844.
* On the same die as J_var → ΔV_GS ≤ 5 mV (LS844 grade match).
R_d_ref    vcc          n_ref_drain   10k
J_ref      n_ref_drain  0             n_ref_src  J_LS844
R_src_ref  n_ref_src    0             100
R_sum_a    v_int_out  n_sum_plus  100k
R_sum_gnd  n_sum_plus 0           100k
R_sum_b    n_ref_src  n_sum_minus 100k
R_sum_fb   v_ctl      n_sum_minus 100k
* AC bootstrap: inject v_drv_atten and n_ap_plus into +IN through 100k
* each via AC-coupling caps. With R_a=R_gnd=R_btd=R_bts=100k all to n_sum_plus,
* +IN AC voltage = (V_int_out + V_drv + V_ap) / 4. Op-amp gain of 2 from +IN
* gives V_ctl_AC = (V_int_out + V_drv + V_ap)/2 - V_source_ref_AC.
* For slow V_int (≈ DC) and slow V_source_ref (≈ DC), the AC term at f0
* is (V_drv + V_ap)/2 = V_avg_DS = V_S_AC + V_DS/2 → V_GS_AC = V_DS/2 →
* the V_DS-dependent term in R_DS cancels (see Lipshitz-Vanderkooy
* "JFETs as Voltage-Controlled Resistors" AES Journal). Brings H2 down
* from ~7-11% to ~3% target.
*
* C_btd = C_bts = 100 nF: at f0=1 kHz, |Z_C| = 1.6 kΩ << R_btd=100 kΩ → cap
* is effectively short at f0. HP cut-off = 1/(2π·100k·100n) ≈ 16 Hz, well
* below f0 so bootstrap is full strength at the operating frequency, and
* well above the loop bandwidth (~few Hz) so DC operation is unaffected.
* Through-hole ceramic / MLCC 100 nF X7R, ~$0.02 each.
C_btd      v_drv_atten n_btd_mid  100n IC=0
R_btd      n_btd_mid   n_sum_plus 100k
C_bts      n_ap_plus   n_bts_mid  100n IC=0
R_bts      n_bts_mid   n_sum_plus 100k
XU_sum     n_sum_plus n_sum_minus vcc vee v_ctl uopamp_lvl3 Avol=10meg GBW=4.5meg Rin=100g Rout=10 Iq=600u Ilimit=65m Vrail=100m Vmax=40 Vos=2.500000e-03

* Buffer 0: passive attenuator on V_osc, then op-amp follower to feed JFET
* with low-Z attenuated drive. R_atten_top:R_atten_bot = 56k:9.1k -> k_atten
* ~ 7.15, so V_drv_atten ~= V_osc / 7.15 (peak ~0.5 V at V_osc 3.6 V_pk),
* keeping V_DS in the JFET's linear region.
R_atten_top  v_osc          v_atten_input 56k
R_atten_bot  v_atten_input  0             9.1k
XU_buf0      v_atten_input  v_drv_atten   vcc vee v_drv_atten uopamp_lvl3 Avol=10meg GBW=4.5meg Rin=100g Rout=10 Iq=600u Ilimit=65m Vrail=100m Vmax=40 Vos=2.500000e-03

* Buffer 1 (CE complementary push-pull): v_drv_atten -> v_osc_drive
* Op-amp + and - inputs SWAPPED relative to standard inverting amp because
* the CE BJT stage is itself inverting -- if we used standard inverting amp
* (signals into V-), the loop would have positive feedback and latch up.
* With signals into V+, the BJT inversion provides the second sign flip
* needed for negative feedback overall.
XU_buf_osc n_buf_osc_sum 0 vcc vee n_buf_osc_out uopamp_lvl3 Avol=10meg GBW=4.5meg Rin=100g Rout=10 Iq=600u Ilimit=65m Vrail=100m Vmax=40 Vos=2.500000e-03
R_buf1_in   v_drv_atten n_buf_osc_sum 1k
R_buf1_fb   v_osc_drive n_buf_osc_sum 2500
R_obb_top   vcc_buf       q_o_bp_top    200
D_obb_top   q_o_bp_top    n_buf_osc_out Dbias
D_obb_bot   n_buf_osc_out q_o_bn_bot   Dbias
R_obb_bot   q_o_bn_bot    vee_buf       200
V_im_o_pmos vcc_buf vcc_buf_o_pmos 0
R_gd_o_pmos q_o_bp_top g_o_pmos 1k
XM_o_pmos v_osc_drive g_o_pmos vcc_buf_o_pmos DMP3098L
V_im_o_nmos vee_buf_o_nmos vee_buf 0
R_gd_o_nmos q_o_bn_bot g_o_nmos 1k
XM_o_nmos v_osc_drive g_o_nmos vee_buf_o_nmos DMN3404L

* Buffer 2 (CE complementary push-pull): v_ap -> v_ap_drive
* DC-block cap on v_ap to kill the JFET-rectification offset before the
* gain stage. C must be sized so the HPF corner against R_buf2_in (1k,
* the AC load at n_buf2_ac since op-amp summing junction is virtual GND)
* is well below f0 = 1 kHz. C = 10 uF gives fc = 16 Hz; smaller caps
* attenuate the carrier (100 nF would have fc = 1.6 kHz, killing 60% of
* the signal at f0).
C_buf2_dcblock v_ap         n_buf2_ac    10u IC=0
R_buf2_dcref   n_buf2_ac    0            100k
* Inverting amp summing junction takes both v_drv_atten (via cap-coupled v_ap)
* and v_ap_drive feedback. R_buf2_in is from n_buf2_ac (AC-coupled v_ap).
XU_buf_ap   n_buf_ap_sum 0 vcc vee n_buf_ap_out uopamp_lvl3 Avol=10meg GBW=4.5meg Rin=100g Rout=10 Iq=600u Ilimit=65m Vrail=100m Vmax=40 Vos=2.500000e-03
R_buf2_in   n_buf2_ac   n_buf_ap_sum  1k
R_buf2_fb   v_ap_drive  n_buf_ap_sum  2500
R_abb_top   vcc_buf       q_a_bp_top    200
D_abb_top   q_a_bp_top    n_buf_ap_out  Dbias
D_abb_bot   n_buf_ap_out q_a_bn_bot    Dbias
R_abb_bot   q_a_bn_bot    vee_buf       200
V_im_a_pmos vcc_buf vcc_buf_a_pmos 0
R_gd_a_pmos q_a_bp_top g_a_pmos 1k
XM_a_pmos v_ap_drive g_a_pmos vcc_buf_a_pmos DMP3098L
V_im_a_nmos vee_buf_a_nmos vee_buf 0
R_gd_a_nmos q_a_bn_bot g_a_nmos 1k
XM_a_nmos v_ap_drive g_a_nmos vee_buf_a_nmos DMN3404L
.model Dbias  D(IS=2.52n N=1.752 RS=0.568 BV=80 IBV=0.1m CJO=4p)
* Schottky (BAT54-class): V_F ~0.3V at 1mA. Used as bias-chain diode for
* sub-threshold class-C operation: 2*V_d_schottky = 0.6V offset between
* BJT bases puts V_BE_quiescent ~0.3V (below 0.6V on threshold), so the
* BJTs only pulse-conduct at AC peaks.
.model Dschottky D(IS=10n N=1.0 RS=0.1 BV=20 IBV=0.1m CJO=10p)
.model QBC337 NPN(IS=1e-14 BF=300 BR=10 RB=10 RC=0.5 RE=0.1 IKF=0.8
+ CJC=11p CJE=20p VAF=100)
.model QBC327 PNP(IS=1e-14 BF=300 BR=10 RB=10 RC=0.5 RE=0.1 IKF=0.8
+ CJC=11p CJE=20p VAF=100)
* Logic-level complementary MOSFET pair: DMP3098L (PMOS) / DMN3404L (NMOS),
* Diodes Inc., SOT-23. Manufacturer subcircuit models (LEVEL=3 internal,
* with junction caps + body diodes) loaded from spice_models/. Terminals
* are 3-pin: drain, gate, source (no external body).
.include /home/lewisbrown/claude-code/smps-design-tools/ngspice_examples/spice_models/DMP3098L.spice.txt
.include /home/lewisbrown/claude-code/smps-design-tools/ngspice_examples/spice_models/DMN3404L.spice.txt

* === 2N3904 ===
.model Q2N3904 NPN(IS=6.734f XTI=3 EG=1.11 VAF=74.03 BF=416.4 NE=1.259
+ ISE=6.734f IKF=66.78m XTB=1.5 BR=.7371 NC=2 ISC=0 IKR=0 RC=1
+ CJC=3.638p MJC=.3085 VJC=.75 FC=.5 CJE=4.493p MJE=.2593 VJE=.75
+ TR=239.5n TF=301.2p ITF=.4 VTF=4 XTF=2 RB=10)

.options reltol=1e-4 abstol=1p chgtol=1f
* Limit stored vectors to just the ones we wrdata -- without this,
* ngspice keeps every external + internal subcircuit node in RAM for the
* full transient. With manufacturer MOSFET subcircuits (DMP3098L/DMN3404L)
* this exhausts host memory at ~1.5 s of sim time.
.save v(v_osc_drive) v(v_ap_drive) v(node_A) v(node_B) v(n_diff) v(n_demout) v(v_ctl) v(v_int_out) v(T_node) v(r_fil) v(v_int_raw) v(e_sat)
.tran 10u 5.0 UIC

.control
run
wrdata _ilc11_8_unused.data v(v_osc_drive) v(v_ap_drive) v(node_A) v(node_B) v(n_diff) v(n_demout) v(v_ctl) v(v_int_out) v(T_node) v(r_fil) v(v_int_raw) v(e_sat)
.endcontrol

.end
