* Wien bridge oscillator with BJT amplitude clamp + base bias divider
*
* alpha = 0.30 is the THD-minimum found by sweep_wien_bias.py.
* Op-amp is Ste Kulov's universal Level-1 macromodel, parameterized to
* a realistic fast-audio-op-amp regime (Avol=10k, GBW=100M, fp=10 kHz).

.include uopamp.lib

* --- Wien positive-feedback network ---
R1   out  ns   10k
C1   ns   np   15.915n  IC=0
R2   np   0    10k
C2   np   0    15.915n  IC=10m

* --- Negative-feedback path with biased-BJT amplitude clamp ---
Rg   nn   0    10k
Rfa  nn   fb   10k
Rfb  fb   out  12k
Q1   fb   b1   out  Q2N3904
Rtop1 fb  b1   168k
Rbot1 b1  out  72k
Q2   out  b2   fb   Q2N3904
Rtop2 out b2   168k
Rbot2 b2  fb   72k

* --- Op-amp ---
XU1  np nn out uopamp_lvl1
+    Avol=10k GBW=100meg Rin=100k Rout=30

.model Q2N3904 NPN(IS=6.734f XTI=3 EG=1.11 VAF=74.03 BF=416.4 NE=1.259
+ ISE=6.734f IKF=66.78m XTB=1.5 BR=.7371 NC=2 ISC=0 IKR=0 RC=1
+ CJC=3.638p MJC=.3085 VJC=.75 FC=.5 CJE=4.493p MJE=.2593 VJE=.75
+ TR=239.5n TF=301.2p ITF=.4 VTF=4 XTF=2 RB=10)

.tran 1u 100m UIC

.control
run
wrdata wien_tran.data v(out) v(np) v(fb)
.endcontrol

.end
