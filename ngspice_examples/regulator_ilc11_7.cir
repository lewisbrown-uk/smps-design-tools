* VFD-filament regulator netlist for ILC1-1/7 (tube=ilc11_7)
* Generated from test_closed_loop.py make_netlist; matches the
* netlist that the corresponding regulator_ilc11_7.asc was
* converted from. Use to cross-check LTspice's generated netlist.

* Closed-loop VFD-filament regulator with thermal model

.include /home/lewisbrown/claude-code/smps-design-tools/ngspice_examples/uopamp.lib

.param T_amb=300.0
.param R_amb=7.70509
.param sigma_eps_A=2.490660e-12
.param C_th=5.100872e-04
.param fil_exp=1.2000

Vcc  vcc 0  9.0
Vee  vee 0 -9.0
* Buffer rails for the class-AB BJT collectors. Class-H envelope-tracking
* servo in booster mode (auto-tunes vcc_buf/vee_buf to V_top_pk + 0.3 V),
* fixed at VCC/VEE in non-booster mode (no buffers to power).
Vcc_buf vcc_buf 0 6.5
Vee_buf vee_buf 0 -6.5

* === Wien bridge oscillator (alpha=0.5) ===
R1   v_osc  ns   10000
C1   ns     np   1.591500e-08  IC=0
R2   np     0    10000
C2   np     0    1.591500e-08  IC=10m
Rg   nn     0    10k
Rfa  nn     fb   10k
Rfb  fb     v_osc  12k
Q1   fb     b1    v_osc Q2N3904
Q2   v_osc  b2    fb    Q2N3904
Rtop1 fb    b1    120000
Rbot1 b1    v_osc 120000
Rtop2 v_osc b2    120000
Rbot2 b2    fb    120000
XU_osc np nn vcc vee v_osc uopamp_lvl3 Avol=10meg GBW=4.5meg Rin=100g Rout=10 Iq=600u Ilimit=65m Vrail=100m Vmax=40 Vos=2.500000e-03

* === JFET-controlled all-pass: V_ap = V_osc * (1 - jwR_DS C)/(1 + jwR_DS C) ===
* All-pass input is taken from v_drv_atten: when a buffer chain is in use,
* this is v_drv_atten (low-Z attenuated signal from Buffer 0); otherwise it
* is v_osc directly. Attenuation keeps V_DS << V_GS-Vto so the JFET stays
* in its linear region, eliminating the asymmetric V_GS shift caused by the
* model's drain/source swap when V_DS reverses polarity.
R_ap1 v_drv_atten n_ap_minus 1590
R_ap2 v_ap  n_ap_minus 1590
* NMOS variable resistor: two DMN3404L back-to-back with sources tied at
* n_var_mid (the canonical bidirectional FET-switch topology). The all-pass
* has V_DS swinging both polarities at the corner frequency; a single MOSFET
* would forward-conduct its body diode on the wrong half-cycle and inject
* 2nd-harmonic distortion that the demodulator captures as a DC bridge
* offset. Back-to-back makes each FET handle its dominant V_DS polarity
* (channel) while its own body diode is reverse-biased.
*
* NMOS chosen over PMOS to allow direct (non-inverting) gate drive from the
* integrator: V_ctl = V_int_out + V_offset (see gate-drive section below).
* With V_offset ~ +2.5 V, V_int_out = 0 puts V_GS well above DMN3404L V_TO
* (~+2.0 V), giving R_DS ≈ 0.1 Ω/FET and the all-pass at τ → 0, |1-H| → 0,
* NO bridge differential drive at cold start. Solves the PMOS-era cold-
* start overshoot where V_int_out = 0 ⇒ V_GS = 0 ⇒ MOSFET off ⇒
* R_DS = ∞ ⇒ |1-H| = 2 ⇒ MAX drive (filament hammered at >1.8 P_OP
* before the loop could wind up to engage the variable-R).
*
* Same DMN3404L as the bridge driver output stage -- no new BOM line item,
* just two more SOT-23 NMOS per circuit (+$1.20).
*
* Total R between v_drv_atten and n_ap_plus = 2 * R_DS_per_FET. For an
* all-pass corner near 1 kHz with C_AP = 1 uF, each FET should sit at
* R_DS ~ 100 ohm in triode (V_GS just past V_th) at OP.
XM_var1 v_drv_atten v_ctl n_var_mid DMN3404L
XM_var2 n_ap_plus    v_ctl n_var_mid DMN3404L
* n_var_mid sees only the two PMOS sources internally; without an external
* DC reference path ngspice can't resolve the node, and in the real circuit
* body-diode leakage mismatch could bias the midpoint asymmetrically (which
* would defeat the back-to-back bidirectional R). 1 Meg to GND gives DC
* reference at negligible signal-path impact (channel R is ~100 ohm, so
* 10000:1 impedance ratio); lower than 10 Meg makes it less noise-prone
* and less leakage-sensitive in low-voltage circuits.
R_var_mid_bias n_var_mid 0 1Meg
C_ap n_ap_plus 0 1.000000e-06    IC=0
XU_ap n_ap_plus n_ap_minus vcc vee v_ap uopamp_lvl3 Avol=10meg GBW=4.5meg Rin=100g Rout=10 Iq=600u Ilimit=65m Vrail=100m Vmax=40 Vos=2.500000e-03

* === Tube filament thermal-electrical macromodel ===
* The filament behaves as a non-linear resistor R(T) = R_amb*(T/T_amb)^fil_exp
* with thermal capacity C_th and radiative cooling sigma*eps*A*(T^4-T_amb^4).
* Encapsulated as a subcircuit so the controller netlist doesn't carry
* behavioural sources directly -- this is a model of the tube itself.
*   Terminals: v_top, v_bot   (filament endpoints, AC drive across these)
*              T_node          (internal thermal node, exposed for monitoring)
*              r_fil           (instantaneous R(T) as voltage, for monitoring)
* All physical parameters are global .params (R_amb, sigma_eps_A, C_th,
* T_amb, fil_exp) so a single instantiation is enough.
.subckt filament v_top v_bot T_node r_fil
* T_node is clamped via max(T, T_amb) in every formula. Physically the
* filament can't sit below ambient (no negative-temperature regime), so
* this clamp doesn't alter behaviour in the operating regime (T >= T_amb
* always). It exists purely as a numerical safety: without it, the
* adaptive solver can occasionally take a bad step where T_node dips
* below 0, at which point the T^4 cooling term explodes in sign and
* drives T_node to -inf in a few rejected timesteps. With the clamp,
* the worst case T_node briefly equals T_amb and the model just sits.
B_fil   v_top v_bot I = (V(v_top) - V(v_bot)) / (R_amb * (max(V(T_node),T_amb)/T_amb)^fil_exp)
B_pelec 0 T_node    I = (V(v_top)-V(v_bot))*(V(v_top)-V(v_bot)) / (R_amb * (max(V(T_node),T_amb)/T_amb)^fil_exp)
B_prad  T_node 0    I = sigma_eps_A * (max(V(T_node),T_amb)^4 - T_amb^4)
C_th    T_node 0    {C_th} IC=300.0
B_R     r_fil 0     V = R_amb * (max(V(T_node),T_amb)/T_amb)^fil_exp
.ends filament

* === AC Wheatstone bridge ===
* Filament arm: V_osc -> filament(thermal) -> node_A -> R_sense -> V_ap
X_filament v_osc_drive node_A T_node r_fil filament
R_sen node_A v_ap_drive 5
* Reference arm: V_osc -> R_top_ref -> node_B -> R_bot_ref -> V_ap.
* Bridge balance R_top_ref / R_bot_ref = R_op / R_sen targets R_op exactly.
R_top_ref v_osc_drive node_B 5000
R_bot_ref node_B v_ap_drive  1000

* === Difference amp (1-op-amp subtractor, gain 1) ===
* Loop polarity bookkeeping:
*   JFET-era: V_int_out + → V_ctl - (inverter) → V_GS_JFET - → pinched
*             → R_DS bigger → drive bigger. Cold filament needs more drive
*             → V_int_out +. Diff-amp natural wiring (n_diff = node_B -
*             node_A) gave cold → demod < 0 → inverting integrator winds
*             V_int_out +. Correct.
*   NMOS+level-shift (current): V_ctl = V_int_out + V_offset (non-inverting
*             summer). V_int_out + → V_ctl + → V_GS + → NMOS more on
*             → R_DS smaller → drive smaller. Cold filament needs more
*             drive → V_int_out -. Diff-amp SWAPPED (n_diff = node_A -
*             node_B) gives cold → demod > 0 → inverting integrator winds
*             V_int_out -. Correct.
* So the swap done for the PMOS era is also right for NMOS+level-shift,
* by coincidence of sign-flipping the (gate-drive polarity) twice
* (PMOS inversion AND inverter removal) — net result: opposite polarity
* from JFET, swapped diff-amp matches.
R_a1 node_A n_diff_plus  1e+06
R_a2 n_diff_plus  0      1e+06
R_b1 node_B n_diff_minus 1e+06
R_b2 n_diff_minus n_diff 1e+06
XU_diff n_diff_plus n_diff_minus vcc vee n_diff uopamp_lvl3 Avol=10meg GBW=4.5meg Rin=100g Rout=10 Iq=600u Ilimit=65m Vrail=100m Vmax=40 Vos=2.500000e-03

* === Comparator (behavioural sign of V_osc) ===
* Comparator: open-loop op-amp (one channel of the second TLV9154 quad).
* V+/V- swapped from the natural "sign of V_osc" connection ONLY when the
* CE booster is on (mc["ce_buf"]=True): in that topology Buffer 2 is an
* inverting summer (sign-flipped). The CC booster (default for non-mos_buf
* tubes like ILC1-1/7) uses non-inverting Buffers 1 and 2, no sign flip,
* so the comparator stays unswapped.
XU_cmp v_osc 0 vcc vee n_cmp uopamp_lvl3 Avol=10meg GBW=4.5meg Rin=100g Rout=10 Iq=600u Ilimit=65m Vrail=100m Vmax=40 Vos=2.500000e-03

* === Polarity-switching demodulator ===
.model swMod SW(VT=0 VH=0.1 RON=10 ROFF=1G)
S1 n_diff vplus n_cmp 0 swMod
S2 0      vplus 0     n_cmp swMod
R_bias vplus 0 1Meg
R_din n_diff n_dem_minus 10k
R_dfb n_demout n_dem_minus 10k
XU_dem vplus n_dem_minus vcc vee n_demout uopamp_lvl3 Avol=10meg GBW=4.5meg Rin=100g Rout=10 Iq=600u Ilimit=50m Vrail=100m Vmax=40 Vos=5.000000e-06

* === Integrator -> V_ctl (loop amp) ===
* V_ctl_raw = -1/(R*C) * integral(V_demout). Cold filament: V_demout < 0,
* so V_ctl_raw integrates positive. We want V_ctl negative when cold so
* the JFET stays pinched off. Wire B_invert to flip sign.
* PID compensator (single-op-amp form):
*   Input: R_INT || C_PID  (the parallel cap adds derivative action)
*   Feedback: R_PID in series with C_INT (the series R adds proportional)
* Transfer function: H(s) = -(R_PID + 1/sC_INT)(1 + sR_INT*C_PID) / R_INT
*   Ki = 1/(R_INT * C_INT)         integrator (DC dominates)
*   Kp = R_PID/R_INT + C_PID/C_INT proportional (mid-band)
*   Kd = R_PID * C_PID             derivative (HF, fights overshoot)
R_intin  n_demout n_int_minus 150000
C_intin  n_demout n_int_minus 1.000000e-09
R_intfb  n_int_pidp v_int_raw 1.5e+06
* Realistic startup: cap begins uncharged (no IC). Loop self-starts from
* the intentional 1% bridge mismatch above + Vos drift in the demod and
* integrator op-amps.
C_intfb  n_int_minus n_int_pidp 3.183099e-07  IC=0
* HF rolloff cap: in parallel with R_PID to limit HF gain and suppress
* the f0 ripple from V_demod that the D term would otherwise pump
* through to V_ctl.
C_hf     n_int_pidp v_int_raw 1.000000e-08     IC=0
* Integrator op-amp output is v_int_raw (free-swinging, no clamp diodes
* on this node). The downstream-visible v_int_out is the upper-clamped
* version produced by the saturator (R_aw_out + D_aw_hi below). The
* back-calc path (R_bc + diff amp) feeds e_sat = v_int_raw - v_int_out
* into n_int_minus, unwinding the integrator only when v_int_raw is past
* the upper clamp -- zero effect when in range.
* DUAL-SUPPLY for the integrator. V_int_out_OP is slightly negative (~-0.4 V
* for ILC1-1/7) with the NMOS variable-R + level-shift architecture
* (V_ctl = V_int_out + V_offset). Cold-start: V_int_out winds from 0 toward
* OP through negative values; the NMOS pair is strongly on at cold start
* (V_GS ≈ V_offset = +2.5 V), so |1-H| ≈ 0 and the filament heats gently.
* No wrong-polarity basin (MOSFET gate is insulated; there's no equivalent
* of the JFET gate-source forward-conduction trap regardless of V_int_out
* sign).
XU_int 0 n_int_minus vcc vee v_int_raw uopamp_lvl3 Avol=10meg GBW=4.5meg Rin=100g Rout=10 Iq=600u Ilimit=50m Vrail=100m Vmax=40 Vos=5.000000e-06

* === Passive saturator + back-calculation anti-windup ===
* The integrator op-amp output v_int_raw drives v_int_out through a series
* resistor R_aw_out. A single upper clamp diode D_aw_hi clips v_int_out to
* V_clamp_hi + Vf. When v_int_raw exceeds the clamp, the clamp diode
* conducts, with current bounded by R_aw_out. The lower bound on v_int_out
* is the integrator op-amp's own VEE rail (no diode clamp needed; the
* NMOS+level-shift architecture has V_int_out_OP negative).
*
* R_aw_out = 10 ohm sizes for the loads on v_int_out (R_sum_in_a = 100k draws
* ~11 uA at OP; the diff amp's R_diff1 draws another ~5 uA): the load drop
* across R_aw_out is ~0.16 mV at OP, which through the back-calc resistor
* would give a ~5 nA bias current at the integrator input -- equivalent to
* ~0.5 K of steady-state T error. Smaller would lower SS error further but
* makes the saturation diode current larger; at R_aw_out = 10 ohm the worst-
* case saturation current is (9 - 3.2)/10 = 580 mA (when v_int_raw rails),
* which is inside the BAS70 / 1N5819 Schottky's 1 A continuous rating.
* (1N4148 has 300 mA continuous / 4 A pulse, so it survives the ~500 ms
* cold-start transient but would not be the right BOM choice.)
* Clamp widened from +2.5 V to +6.0 V to give the loop room for the
* JMMBFJ112's V_p range (-1 to -5 V). With the +6 V upper clamp, V_ctl
* can swing to -6 V, comfortably accommodating worst-case V_p = -5 parts
* without engaging the clamp at OP. Cold-start kick still hits the clamp
* (which is the intended anti-windup behaviour during slew). The +/-9 V
* op-amp supplies easily accommodate +6 V on V_int_out.
V_clamp_hi v_clamp_hi 0  6
V_clamp_lo v_clamp_lo 0  -0.7
R_aw_out   v_int_raw  v_int_out  10
D_aw_hi    v_int_out  v_clamp_hi Dclamp
D_aw_lo    v_clamp_lo v_int_out  Dclamp
* Lower clamp at V_clamp_lo = -0.7 V → V_int_out floor ≈ -1.0 V (Schottky
* V_F ≈ 0.3 V at saturation current). Without it, the loop's proportional
* gain (Kp=10) sends V_int_out to the integrator's negative rail (~-5 V)
* in milliseconds at cold start, and the 100+ ms recovery from saturation
* drives a +68 K overshoot. With the clamp + back-calc anti-windup
* (R_bc), V_int_out is bounded at ~-1 V, anti-windup unwinds the
* integrator quickly when the loop transitions out of the cold-start
* high-error regime.
* Dclamp: switched 2026-05 from 1N4148-class to Schottky (BAT54 / 1N5819).
* Reason: at the worst-case clamp current (op-amp Isc ~50 mA chopper),
* the 1N4148's V_F was ~0.76 V; that meant the effective V_int_out floor
* sat at V_clamp_lo - 0.76 = -0.46 V even with V_clamp_lo = +0.3 V. V_ctl
* (via inverter, +1*V_int_out) crossed the JFET gate-source forward
* threshold (~0.6 V) on AC peaks, latching the loop in a "wrong-polarity"
* steady state where the JFET gate diode forward-conducts. With Schottky
* V_F ~0.3 V at 50 mA, the effective floor is V_clamp_lo - 0.3 ≈ 0 V,
* so V_ctl stays comfortably below the gate-conduction threshold. The
* lvl3 op-amp current verification (verify_opamp_currents.py) exposed
* the bistability when Ilimit was tightened from 1 A to 50/65 mA.
* Schottky (BAT54 / 1N5819 class). Higher SOA than 1N4148 for the
* worst-case clamp engagement current (~ Ilimit at full op-amp saturation).
.model Dclamp D(Is=10n N=1.0 RS=0.1 BV=40 IBV=0.1m CJO=10p)

* Difference op-amp: e_sat = v_int_raw - v_int_out (the "saturation error").
* Zero when v_int_out follows v_int_raw (no clamp current), positive when
* upper clamp diode conducts (v_int_raw > v_int_out), negative when lower
* clamp diode conducts. Standard 4-resistor difference topology, unity
* gain. Sign convention: v_int_raw is on the +IN side, v_int_out on the -IN
* side so e_sat = v_int_raw - v_int_out (so R_bc opposes integrator
* wind-up, not reinforces it).
R_diff1 v_int_out n_aw_diff_minus 100k
R_diff2 v_int_raw n_aw_diff_plus  100k
R_diff3 n_aw_diff_minus e_sat     100k
R_diff4 n_aw_diff_plus  0         100k
* Chopper-stabilized op-amp (Vos ~ 5 uV vs 2.5 mV for standard) for the
* back-calc diff amp. Tight Vos is essential here: e_sat's DC value is
* multiplied by 1/R_bc to become an integrator bias current, which the
* closed loop has to compensate with a corresponding steady-state demod
* error. With R_bc=R_INT (set below), the bias from a 2.5 mV Vos creates
* a ~33 K T error; chopper-class Vos cuts that to <0.1 K.
XU_aw_diff n_aw_diff_plus n_aw_diff_minus vcc vee e_sat uopamp_lvl3 Avol=10meg GBW=4.5meg Rin=100g Rout=10 Iq=600u Ilimit=50m Vrail=100m Vmax=40 Vos=5.000000e-06

* Back-calc resistor: routes e_sat to n_int_minus (integrator's summing
* junction). When v_int_raw > clamp_hi, e_sat > 0 -> injects positive current
* into n_int_minus, which the integrator counter-integrates -> v_int_raw is
* pulled back toward v_int_out at rate ~1/(R_bc * C_INT). Symmetric on the
* low side.
*
* Sizing: R_bc = R_INT sets the back-calc tracking time constant to
* R_INT*C_INT = ~9.5 ms, much faster than the thermal pole (100 ms) so
* anti-windup acts well within the regulator's response window. The DC
* leakage (chopper-class Vos -> e_sat offset -> bias current at
* n_int_minus) is negligible: 5 uV * 1 = 5 uV demand error, < 0.1 K.
R_bc e_sat n_int_minus 150000

* === Variable-R gate drive: non-inverting summer with DC level shift ===
* V_ctl = V_int_out + V_offset, with V_offset ≈ +2.5 V.
* Picks V_GS_DC at V_int_out = 0 well above DMN3404L V_TO (~+2.0 V from
* SPICE model), so the NMOS pair is in strong inversion at cold start:
* R_DS ≈ 0.1 Ω/FET → all-pass τ → 0 → |1-H| → 0 → NO bridge differential
* drive at t = 0. Cold-start filament heats gently as the loop modulates
* V_int_out toward V_int_out_OP (negative, ≈ -0.4 V for ILC1-1/7); no
* windup overshoot mechanism.
*
* V_offset implementation in hardware: a precision +2.5 V voltage
* reference. Practical options:
*   - LM4040-2.5 (shunt ref, 0.1% grade ~$0.60)
*   - TL431 (programmable shunt, set to 2.5 V via 1:1 R divider; ~$0.10)
*   - Zener-regulated VCC + divider (cheap but more tempco)
* DC accuracy on V_offset is not critical: drift translates 1:1 to V_GS_DC
* shift, which the closed loop compensates by shifting V_int_out_OP.
* T_op is unaffected because the bridge balance condition sets T.
V_offset_ref v_offset_ref 0 2
* Non-inverting summer:
*   V_+IN at n_sum_plus = (V_int_out + V_offset) / 2 (two equal 100k Rs).
*   Op-amp closed-loop gain from +IN = 1 + R_sum_fb/R_sum_gnd = 1 + 100k/100k = 2.
*   Therefore V_ctl = 2 · V(n_sum_plus) = V_int_out + V_offset.
* Same opamp model as the rest of the loop (TLV9154-class). Output drives
* the high-impedance MOSFET gates directly; no current beyond Iq.
R_sum_in_a  v_int_out     n_sum_plus   100k
R_sum_in_b  v_offset_ref  n_sum_plus   100k
R_sum_fb    v_ctl         n_sum_minus  100k
R_sum_gnd   n_sum_minus   0            100k
XU_sum      n_sum_plus    n_sum_minus  vcc vee v_ctl uopamp_lvl3 Avol=10meg GBW=4.5meg Rin=100g Rout=10 Iq=600u Ilimit=65m Vrail=100m Vmax=40 Vos=2.500000e-03

* Buffer 0: passive attenuator on V_osc, then op-amp follower to feed JFET
* with low-Z attenuated drive. R_atten_top:R_atten_bot = 56k:9.1k -> k_atten
* ~ 7.15, so V_drv_atten ~= V_osc / 7.15 (peak ~0.5 V at V_osc 3.6 V_pk),
* keeping V_DS in the JFET's linear region.
R_atten_top  v_osc          v_atten_input 56k
R_atten_bot  v_atten_input  0             9.1k
XU_buf0      v_atten_input  v_drv_atten   vcc vee v_drv_atten uopamp_lvl3 Avol=10meg GBW=4.5meg Rin=100g Rout=10 Iq=600u Ilimit=65m Vrail=100m Vmax=40 Vos=2.500000e-03

* Buffer 1 (CC emitter follower): V_drv_atten -> V_osc_drive (gain k_buf,
* class-AB BC337/BC327). Bootstrap caps from output to bias-chain midpoints
* lift the bias rail with the signal so the BJT base can drive past vcc_buf
* / vee_buf at peak swing. Feedback divider R_buf1_fb1:R_buf1_fb2 sets k_buf.
XU_buf_osc   v_drv_atten n_buf_osc_fb vcc_buf vee_buf n_buf_osc_out uopamp_lvl3 Avol=10meg GBW=4.5meg Rin=100g Rout=10 Iq=600u Ilimit=65m Vrail=100m Vmax=40 Vos=2.500000e-03
R_buf1_fb1   v_osc_drive n_buf_osc_fb 13000
R_buf1_fb2   n_buf_osc_fb 0           1k
R_obb_top_a  vcc_buf      mid_obb_top  680
R_obb_top_b  mid_obb_top  q_o_bn       680
C_obb_top    mid_obb_top  v_osc_drive  4.7u IC=0
D_obb_top    q_o_bn       n_buf_osc_out Dbias
D_obb_bot    n_buf_osc_out q_o_bp      Dbias
R_obb_bot_b  q_o_bp       mid_obb_bot  680
R_obb_bot_a  mid_obb_bot  vee_buf      680
C_obb_bot    mid_obb_bot  v_osc_drive  4.7u IC=0
Q_o_npn  vcc_buf q_o_bn v_osc_drive QBC337
Q_o_pnp  vee_buf q_o_bp v_osc_drive QBC327

* Buffer 2 (CC emitter follower): V_ap -> V_ap_drive (gain k_buf_ap).
C_buf2_dcblock v_ap         n_buf2_ac    100n IC=0
R_buf2_dcref   n_buf2_ac    0            100k
XU_buf_ap    n_buf2_ac   n_buf_ap_fb     vcc_buf vee_buf n_buf_ap_out uopamp_lvl3 Avol=10meg GBW=4.5meg Rin=100g Rout=10 Iq=600u Ilimit=65m Vrail=100m Vmax=40 Vos=2.500000e-03
R_buf2_fb1   v_ap_drive  n_buf_ap_fb     13000
R_buf2_fb2   n_buf_ap_fb 0               1k
R_abb_top_a  vcc_buf      mid_abb_top  680
R_abb_top_b  mid_abb_top  q_a_bn       680
C_abb_top    mid_abb_top  v_ap_drive   4.7u IC=0
D_abb_top    q_a_bn       n_buf_ap_out Dbias
D_abb_bot    n_buf_ap_out q_a_bp       Dbias
R_abb_bot_b  q_a_bp       mid_abb_bot  680
R_abb_bot_a  mid_abb_bot  vee_buf      680
C_abb_bot    mid_abb_bot  v_ap_drive   4.7u IC=0
Q_a_npn  vcc_buf q_a_bn v_ap_drive QBC337
Q_a_pnp  vee_buf q_a_bp v_ap_drive QBC327
.model Dbias  D(IS=2.52n N=1.752 RS=0.568 BV=80 IBV=0.1m CJO=4p)
* Schottky (BAT54-class): V_F ~0.3V at 1mA. Used as bias-chain diode for
* sub-threshold class-C operation: 2*V_d_schottky = 0.6V offset between
* BJT bases puts V_BE_quiescent ~0.3V (below 0.6V on threshold), so the
* BJTs only pulse-conduct at AC peaks.
.model Dschottky D(IS=10n N=1.0 RS=0.1 BV=20 IBV=0.1m CJO=10p)
.model QBC337 NPN(IS=1e-14 BF=300 BR=10 RB=10 RC=0.5 RE=0.1 IKF=0.8
+ CJC=11p CJE=20p VAF=100)
.model QBC327 PNP(IS=1e-14 BF=300 BR=10 RB=10 RC=0.5 RE=0.1 IKF=0.8
+ CJC=11p CJE=20p VAF=100)
* Logic-level complementary MOSFET pair: DMP3098L (PMOS) / DMN3404L (NMOS),
* Diodes Inc., SOT-23. Manufacturer subcircuit models (LEVEL=3 internal,
* with junction caps + body diodes) loaded from spice_models/. Terminals
* are 3-pin: drain, gate, source (no external body).
.include /home/lewisbrown/claude-code/smps-design-tools/ngspice_examples/spice_models/DMP3098L.spice.txt
.include /home/lewisbrown/claude-code/smps-design-tools/ngspice_examples/spice_models/DMN3404L.spice.txt

* === 2N3904 ===
.model Q2N3904 NPN(IS=6.734f XTI=3 EG=1.11 VAF=74.03 BF=416.4 NE=1.259
+ ISE=6.734f IKF=66.78m XTB=1.5 BR=.7371 NC=2 ISC=0 IKR=0 RC=1
+ CJC=3.638p MJC=.3085 VJC=.75 FC=.5 CJE=4.493p MJE=.2593 VJE=.75
+ TR=239.5n TF=301.2p ITF=.4 VTF=4 XTF=2 RB=10)

.options reltol=1e-4 abstol=1p chgtol=1f
* Limit stored vectors to just the ones we wrdata -- without this,
* ngspice keeps every external + internal subcircuit node in RAM for the
* full transient. With manufacturer MOSFET subcircuits (DMP3098L/DMN3404L)
* this exhausts host memory at ~1.5 s of sim time.
.save v(v_osc_drive) v(v_ap_drive) v(node_A) v(node_B) v(n_diff) v(n_demout) v(v_ctl) v(v_int_out) v(T_node) v(r_fil) v(v_int_raw) v(e_sat)
.tran 10u 5.0 UIC

.control
run
wrdata _ilc11_7_unused.data v(v_osc_drive) v(v_ap_drive) v(node_A) v(node_B) v(n_diff) v(n_demout) v(v_ctl) v(v_int_out) v(T_node) v(r_fil) v(v_int_raw) v(e_sat)
.endcontrol

.end
