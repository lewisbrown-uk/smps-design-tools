* VFD-filament regulator netlist for ILC1-1/7 (tube=ilc11_7)
* Generated from test_closed_loop.py make_netlist; matches the
* netlist that the corresponding regulator_ilc11_7.asc was
* converted from. Use to cross-check LTspice's generated netlist.

* Closed-loop VFD-filament regulator with thermal model

.include /home/user/smps-design-tools/ngspice_examples/uopamp.lib

.param T_amb=300.0
.param R_amb=7.70509
.param sigma_eps_A=2.490660e-12
.param C_th=5.100872e-04
.param fil_exp=1.2000

Vcc  vcc 0  9.0
Vee  vee 0 -9.0

* === Wien bridge oscillator (alpha=0.5) ===
R1   v_osc  ns   10000
C1   ns     np   1.591500e-08  IC=0
R2   np     0    10000
C2   np     0    1.591500e-08  IC=10m
Rg   nn     0    10k
Rfa  nn     fb   10k
Rfb  fb     v_osc  12k
Q1   fb     b1    v_osc Q2N3904
Q2   v_osc  b2    fb    Q2N3904
Rtop1 fb    b1    120000
Rbot1 b1    v_osc 120000
Rtop2 v_osc b2    120000
Rbot2 b2    fb    120000
XU_osc np nn vcc vee v_osc uopamp_lvl2 Avol=10meg GBW=4.5meg Rin=100g Rout=10 Iq=600u Ilimit=1 Vrail=100m Vmax=40 Vos=2.500000e-03

* === JFET-controlled all-pass: V_ap = V_osc * (1 - jwR_DS C)/(1 + jwR_DS C) ===
* All-pass input is taken from v_drv_atten: when a buffer chain is in use,
* this is v_drv_atten (low-Z attenuated signal from Buffer 0); otherwise it
* is v_osc directly. Attenuation keeps V_DS << V_GS-Vto so the JFET stays
* in its linear region, eliminating the asymmetric V_GS shift caused by the
* model's drain/source swap when V_DS reverses polarity.
R_ap1 v_drv_atten n_ap_minus 1590
R_ap2 v_ap  n_ap_minus 1590
* JFET R_DS in series from V_drv_atten (or V_osc) to V+ (cap-shunted node).
J_var v_drv_atten v_ctl n_ap_plus J201
C_ap n_ap_plus 0 1.000000e-06    IC=0
XU_ap n_ap_plus n_ap_minus vcc vee v_ap uopamp_lvl2 Avol=10meg GBW=4.5meg Rin=100g Rout=10 Iq=600u Ilimit=1 Vrail=100m Vmax=40 Vos=2.500000e-03
.model J201 NJF(Vto=-1.5000 Beta=1.0000e-03 Lambda=0)

* === Tube filament thermal-electrical macromodel ===
* The filament behaves as a non-linear resistor R(T) = R_amb*(T/T_amb)^fil_exp
* with thermal capacity C_th and radiative cooling sigma*eps*A*(T^4-T_amb^4).
* Encapsulated as a subcircuit so the controller netlist doesn't carry
* behavioural sources directly -- this is a model of the tube itself.
*   Terminals: v_top, v_bot   (filament endpoints, AC drive across these)
*              T_node          (internal thermal node, exposed for monitoring)
*              r_fil           (instantaneous R(T) as voltage, for monitoring)
* All physical parameters are global .params (R_amb, sigma_eps_A, C_th,
* T_amb, fil_exp) so a single instantiation is enough.
.subckt filament v_top v_bot T_node r_fil
B_fil   v_top v_bot I = (V(v_top) - V(v_bot)) / (R_amb * (V(T_node)/T_amb)^fil_exp)
B_pelec 0 T_node    I = (V(v_top)-V(v_bot))*(V(v_top)-V(v_bot)) / (R_amb * (V(T_node)/T_amb)^fil_exp)
B_prad  T_node 0    I = sigma_eps_A * (V(T_node)^4 - T_amb^4)
C_th    T_node 0    {C_th} IC=300.0
B_R     r_fil 0     V = R_amb * (V(T_node)/T_amb)^fil_exp
.ends filament

* === AC Wheatstone bridge ===
* Filament arm: V_osc -> filament(thermal) -> node_A -> R_sense -> V_ap
X_filament v_osc_drive node_A T_node r_fil filament
R_sen node_A v_ap_drive 5
* Reference arm: V_osc -> R_top_ref -> node_B -> R_sense_ref -> V_ap
* R_top_ref nominal 99 ohm (1% off the 100-ohm filament target) so the bridge
* has a non-zero error signal at cold-start. With MC on, this is multiplied
* by k_r_top_ref tolerance.
R_top_ref v_osc_drive node_B 5000
R_bot_ref node_B v_ap_drive  1000

* === Difference amp (1-op-amp subtractor, gain 1) ===
R_a1 node_A n_diff_minus 1e+06
R_a2 n_diff_minus n_diff 1e+06
R_b1 node_B n_diff_plus 1e+06
R_b2 n_diff_plus 0 1e+06
XU_diff n_diff_plus n_diff_minus vcc vee n_diff uopamp_lvl2 Avol=10meg GBW=4.5meg Rin=100g Rout=10 Iq=600u Ilimit=1 Vrail=100m Vmax=40 Vos=2.500000e-03

* === Comparator (behavioural sign of V_osc) ===
* Comparator: open-loop op-amp (one channel of the second TLV9154 quad).
* V+ = v_osc, V- = 0; output saturates to ~+/-(Vcc - Vrail) on each rail
* whenever |V_osc| exceeds the input-referred Vos. Slew-rate / GBW determine
* the rise/fall time of the comparator output (fast at 4.5 MHz GBW vs
* the 1 kHz V_osc); Vos creates a small zero-crossing offset that the
* synchronous demodulator inherits as a phase shift in its reference.
XU_cmp v_osc 0 vcc vee n_cmp uopamp_lvl2 Avol=10meg GBW=4.5meg Rin=100g Rout=10 Iq=600u Ilimit=1 Vrail=100m Vmax=40 Vos=2.500000e-03

* === Polarity-switching demodulator ===
.model swMod SW(VT=0 VH=0.1 RON=10 ROFF=1G)
S1 n_diff vplus n_cmp 0 swMod
S2 0      vplus 0     n_cmp swMod
R_bias vplus 0 1Meg
R_din n_diff n_dem_minus 10k
R_dfb n_demout n_dem_minus 10k
XU_dem vplus n_dem_minus vcc vee n_demout uopamp_lvl2 Avol=10meg GBW=4.5meg Rin=100g Rout=10 Iq=600u Ilimit=1 Vrail=100m Vmax=40 Vos=5.000000e-06

* === Integrator -> V_ctl (loop amp) ===
* V_ctl_raw = -1/(R*C) * integral(V_demout). Cold filament: V_demout < 0,
* so V_ctl_raw integrates positive. We want V_ctl negative when cold so
* the JFET stays pinched off. Wire B_invert to flip sign.
* PID compensator (single-op-amp form):
*   Input: R_INT || C_PID  (the parallel cap adds derivative action)
*   Feedback: R_PID in series with C_INT (the series R adds proportional)
* Transfer function: H(s) = -(R_PID + 1/sC_INT)(1 + sR_INT*C_PID) / R_INT
*   Ki = 1/(R_INT * C_INT)         integrator (DC dominates)
*   Kp = R_PID/R_INT + C_PID/C_INT proportional (mid-band)
*   Kd = R_PID * C_PID             derivative (HF, fights overshoot)
R_intin  n_demout n_int_minus 30000
C_intin  n_demout n_int_minus 1.000000e-09
R_intfb  n_int_pidp v_int_out 300000
* Realistic startup: cap begins uncharged (no IC). Loop self-starts from
* the intentional 1% bridge mismatch above + Vos drift in the demod and
* integrator op-amps.
C_intfb  n_int_minus n_int_pidp 3.183099e-07  IC=0
* HF rolloff cap: in parallel with R_PID to limit HF gain and suppress
* the f0 ripple from V_demod that the D term would otherwise pump
* through to V_ctl.
C_hf     n_int_pidp v_int_out 1.000000e-08     IC=0
XU_int 0 n_int_minus vcc vee v_int_out uopamp_lvl2 Avol=10meg GBW=4.5meg Rin=100g Rout=10 Iq=600u Ilimit=1 Vrail=100m Vmax=40 Vos=5.000000e-06

* Anti-windup: real-circuit clamp on V_int_out using two silicon diodes
* referenced to precision voltage sources. The diodes forward-conduct when
* V_int_out exceeds +1.0 V (Vf ~0.7V over the +0.3V reference) or goes
* below -0.4 V (Vf ~0.7V under the -1.1V reference), pulling V_int_out
* back into [-0.4, +1.0]. The integrator op-amp's open-loop drive
* against the diode's finite Ron sets the steady-state clamp accuracy
* (~tens of mV).
* In production the precision references would be Zeners + dividers off
* the +/-9 V rails, or band-gap parts (TL431, REF03 etc.).
V_clamp_hi v_clamp_hi 0  0.3
V_clamp_lo v_clamp_lo 0 -1.1
D_aw_hi    v_int_out  v_clamp_hi Dclamp
D_aw_lo    v_clamp_lo v_int_out  Dclamp
.model Dclamp D(IS=1n N=2.0 RS=100)

* Inverter: V_ctl = -V_int_out via op-amp unity-gain inverting stage.
* Replaces the previous B_ctl behavioural source. The JFET's intrinsic
* gate-source diode forward-conducts at ~+0.6 V which acts as a soft
* upper limit on V_ctl on its own; the V_int_out clamp above limits
* it to +0.4 V well before that, so the JFET gate sees a clean signal.
R_inv1 v_int_out n_inv_minus 100k
R_inv2 n_inv_minus v_ctl     100k
XU_inv 0 n_inv_minus vcc vee v_ctl uopamp_lvl2 Avol=10meg GBW=4.5meg Rin=100g Rout=10 Iq=600u Ilimit=1 Vrail=100m Vmax=40 Vos=2.500000e-03

* === Soft-start network (V_PRESET = 0.55, T_RAMP = 0.1 s) ===
* During the first T_RAMP seconds, a switch ties v_int_out to V_PRESET
* via a low-Z path, forcing the integrator output into the neighbourhood
* of its expected steady state. After T_RAMP the switch opens and the
* loop takes over. T_RAMP=0 disables (loop starts from zero).
* VT=0.5 / VH=0 makes the switch trip cleanly at V_ss=0.5 (i.e., closed when
* V_ss = 1 during the ramp, opens when V_ss = 0 after).
.model swSS SW(VT=0.5 VH=0 RON=0.01 ROFF=1G)
V_preset_src v_preset_node 0 0.5500
V_ss vss 0 PWL(0 1 9.999900e-02 1 1.000000e-01 0 1 0)
S_ss v_int_out v_preset_node vss 0 swSS

* Buffer 0: passive attenuator on V_osc, then op-amp follower to feed JFET
* with low-Z attenuated drive. R_atten_top:R_atten_bot = 56k:9.1k -> k_atten
* ~ 7.15, so V_drv_atten ~= V_osc / 7.15 (peak ~0.5 V at V_osc 3.6 V_pk),
* keeping V_DS in the JFET's linear region.
R_atten_top  v_osc          v_atten_input 56k
R_atten_bot  v_atten_input  0             9.1k
XU_buf0      v_atten_input  v_drv_atten   vcc vee v_drv_atten uopamp_lvl2 Avol=10meg GBW=4.5meg Rin=100g Rout=10 Iq=600u Ilimit=1 Vrail=100m Vmax=40 Vos=2.500000e-03

* Buffer 1: V_drv_atten -> V_osc_drive (gain k_buf, class-AB BC337/BC327)
* Feedback divider R_buf1_fb1:R_buf1_fb2 sets per-tube k_buf
XU_buf_osc   v_drv_atten n_buf_osc_fb vcc vee n_buf_osc_out uopamp_lvl2 Avol=10meg GBW=4.5meg Rin=100g Rout=10 Iq=600u Ilimit=1 Vrail=100m Vmax=40 Vos=2.500000e-03
R_buf1_fb1   v_osc_drive n_buf_osc_fb 9100
R_buf1_fb2   n_buf_osc_fb 0           1k
R_obb_top vcc q_o_bn 680
D_obb_top q_o_bn n_buf_osc_out Dbias
D_obb_bot n_buf_osc_out q_o_bp Dbias
R_obb_bot q_o_bp vee 680
Q_o_npn  vcc q_o_bn v_osc_drive QBC337
Q_o_pnp  vee q_o_bp v_osc_drive QBC327

* Buffer 2: V_ap -> V_ap_drive (gain k_buf, class-AB BC337/BC327)
XU_buf_ap    v_ap        n_buf_ap_fb  vcc vee n_buf_ap_out uopamp_lvl2 Avol=10meg GBW=4.5meg Rin=100g Rout=10 Iq=600u Ilimit=1 Vrail=100m Vmax=40 Vos=2.500000e-03
R_buf2_fb1   v_ap_drive  n_buf_ap_fb  9100
R_buf2_fb2   n_buf_ap_fb 0            1k
R_abb_top vcc q_a_bn 680
D_abb_top q_a_bn n_buf_ap_out Dbias
D_abb_bot n_buf_ap_out q_a_bp Dbias
R_abb_bot q_a_bp vee 680
Q_a_npn  vcc q_a_bn v_ap_drive QBC337
Q_a_pnp  vee q_a_bp v_ap_drive QBC327
.model Dbias  D(IS=2.52n N=1.752 RS=0.568 BV=80 IBV=0.1m CJO=4p)
.model QBC337 NPN(IS=1e-14 BF=300 BR=10 RB=10 RC=0.5 RE=0.1 IKF=0.8
+ CJC=11p CJE=20p VAF=100)
.model QBC327 PNP(IS=1e-14 BF=300 BR=10 RB=10 RC=0.5 RE=0.1 IKF=0.8
+ CJC=11p CJE=20p VAF=100)

* === 2N3904 ===
.model Q2N3904 NPN(IS=6.734f XTI=3 EG=1.11 VAF=74.03 BF=416.4 NE=1.259
+ ISE=6.734f IKF=66.78m XTB=1.5 BR=.7371 NC=2 ISC=0 IKR=0 RC=1
+ CJC=3.638p MJC=.3085 VJC=.75 FC=.5 CJE=4.493p MJE=.2593 VJE=.75
+ TR=239.5n TF=301.2p ITF=.4 VTF=4 XTF=2 RB=10)

.options reltol=1e-6 abstol=1p chgtol=1f
.tran 10u 5.0 UIC

.control
run
wrdata /home/user/smps-design-tools/ngspice_examples/_ilc11_7_unused.data v(v_osc_drive) v(v_ap_drive) v(node_A) v(node_B) v(n_diff) v(n_demout) v(v_ctl) v(v_int_out) v(T_node) v(r_fil)
.endcontrol

.end
