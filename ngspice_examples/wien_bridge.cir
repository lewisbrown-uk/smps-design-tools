* Wien bridge oscillator with diode-connected-2N3904 amplitude limiting
* f0 = 1 / (2*pi*R*C) = 1 kHz  (R=10k, C=15.915n)  -> 100 cycles = 100 ms

* --- Wien positive-feedback network: out -> non-inverting input (np) ---
* Series arm (high-pass): R1 in series with C1
* Shunt arm (low-pass):   R2 in parallel with C2
R1   out  ns   10k
C1   ns   np   15.915n  IC=0
R2   np   0    10k
C2   np   0    15.915n  IC=10m       ; small power-on charge on shunt cap kicks startup

* --- Negative feedback with diode-connected 2N3904 amplitude clamp ---
* Small-signal gain = 1 + (Rfa+Rfb)/Rg = 1 + 22k/10k = 3.2 for startup.
* Q1, Q2 are antiparallel: each has base shorted to collector, so the BE
* junction acts as the clamping diode. Q1 conducts when V(fb) > V(out)+Vbe;
* Q2 conducts when V(out) > V(fb)+Vbe. The 2N3904 has finite beta so a
* small base current flows through the (now zero-resistance) BC short --
* this softens the knee slightly compared to a plain signal diode.
Rg   nn   0    10k
Rfa  nn   fb   10k
Rfb  fb   out  12k
Q1   fb   fb   out  Q2N3904        ; anode=fb, cathode=out
Q2   out  out  fb   Q2N3904        ; anode=out, cathode=fb

* --- Behavioural op-amp: A0=1e5, +/-15 V rails, 100 kHz pole, unity-gain buffer ---
Bgain oe   0   V = max(-15, min(15, 1e5*(V(np)-V(nn))))
Rop   oe   oa  1k
Cop   oa   0   1.59n     IC=0
Ebuf  out  0   oa  0     1.0

* Standard Motorola 2N3904 SPICE model.
.model Q2N3904 NPN(IS=6.734f XTI=3 EG=1.11 VAF=74.03 BF=416.4 NE=1.259
+ ISE=6.734f IKF=66.78m XTB=1.5 BR=.7371 NC=2 ISC=0 IKR=0 RC=1
+ CJC=3.638p MJC=.3085 VJC=.75 FC=.5 CJE=4.493p MJE=.2593 VJE=.75
+ TR=239.5n TF=301.2p ITF=.4 VTF=4 XTF=2 RB=10)

.tran 10u 100m UIC

.control
run
wrdata wien_tran.data v(out) v(np) v(fb)
.endcontrol

.end
